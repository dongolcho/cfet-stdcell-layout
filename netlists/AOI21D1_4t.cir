* AOI21D1: ZN = !((A1 & A2) | B), CFET 4T (Sherazi et al., SPIE 2019, Figure 7)
* Bottom tier pFET, top tier nFET. Each transistor has two nanosheets of 5 nm drawn width,
* so W is the drawn width 2 x 5 nm, and L is the gate width 14 nm (cfet_rules.md).
* Element order: M<name> drain gate source bulk model
.SUBCKT AOI21D1 A1 A2 B ZN VDD VSS
* pull-up: VDD - B - X - (A1 || A2) - ZN
MPB  X  B  VDD VDD PMOS L=14n W=10n
MPA1 ZN A1 X   VDD PMOS L=14n W=10n
MPA2 ZN A2 X   VDD PMOS L=14n W=10n
* pull-down: ZN - A1 - N1 - A2 - VSS, and ZN - B - VSS
MNA1 ZN A1 N1  VSS NMOS L=14n W=10n
MNA2 N1 A2 VSS VSS NMOS L=14n W=10n
MNB  ZN B  VSS VSS NMOS L=14n W=10n
.ENDS
